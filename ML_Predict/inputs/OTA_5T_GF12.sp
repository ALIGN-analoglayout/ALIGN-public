// Design cell name: 5T_OTA_AC1_testbench
simulator lang=spectre
global 0

parameters vcm_r=0.675 wireopt=5 vdd_r=1

// GF12nm_OTA_schematic/beta_multiplier_bias/schematic
subckt beta_multiplier_bias IBIASN VDD VSS
    P2 (IBIASN net10 VDD VDD) pmos m=1 l=14n nfin=12 nf=1
    P1 (net6 net10 VDD VDD) pmos m=1 l=14n nfin=12 nf=1
    P0 (net10 net10 VDD VDD) pmos m=1 l=14n nfin=12 nf=1
    N1 (net6 net6 VSS VSS) nmos m=1 l=14n nfin=12 nf=1
    N0 (net10 net6 net19 net19) nmos m=1 l=14n nfin=40 nf=1
    R0 (VSS net19 VSS) rmres m=1 w=1u l=2u r=968.205
ends beta_multiplier_bias

P2 (n0 n11 VDD VDD) pmos m=1 l=14n nfin=12 nf=1
P1 (n12 n11 VDD VDD) pmos m=1 l=14n nfin=12 nf=1
P0 (n11 n11 VDD VDD) pmos m=1 l=14n nfin=12 nf=1
N1 (n12 n12 0 0) nmos m=1 l=14n nfin=12 nf=1
N0 (n11 n12 n13 n13) nmos m=1 l=14n nfin=40 nf=1
R0 (0 n13 0) rmres m=1 w=1u l=2u r=968.205

//subckt M4_M5 n2 n3 VDD
//M5 (n3 n2 VDD VDD) pmos m=1 l=14n nfin=15 nf=2
//M4 (n2 n2 VDD VDD) pmos m=1 l=14n nfin=15 nf=2
//ends M4_M5

M3 (n3 n9 n1 n1) nmos m=1 l=14n nfin=40 nf=2
M2 (n2 n10 n1 n1) nmos m=1 l=14n nfin=40 nf=2
M0 (n0 n0 0 0) nmos m=1 l=14n nfin=6 nf=2
M1 (n1 n0 0 0) nmos m=1 l=14n nfin=6 nf=6
M5 (n3 n2 VDD VDD) pmos m=1 l=14n nfin=16 nf=2
M4 (n2 n2 VDD VDD) pmos m=1 l=14n nfin=16 nf=2

// GF12nm_OTA_schematic/5T_OTA_AC1_testbench/schematic
//I0 (net3 net5 net6 VOUT 0) GF12nm_OTA_schematic_5T_OTA_schematic
v4 VDD 0 vsource dc=vdd_r type=dc
v6 n9 0 vsource dc=vcm_r mag=-0.5 type=dc
v7 n10 0 vsource dc=vcm_r mag=0.5 type=dc
C0 n3 0 capacitor c=100.0f
simulatorOptions options temp=27
dcOp dc
ac ac start=1000 stop=100G dec=10
tran tran start=0 stop=15e-9 step=1e-12
