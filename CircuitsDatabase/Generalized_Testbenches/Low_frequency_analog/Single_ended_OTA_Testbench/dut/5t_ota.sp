** Library name: MyProjects
** Cell name: 5T_OTA
.subckt DUT vp vn vout vdd vss ibias
m5 ibias ibias vss vss nch_lvt l=m5_l w='m5_w*1' m=1 nf=1 sd=200e-9 ad='((1-int(500e-3)*2)*175e-9+(2-int(1.0)*2)*100e-9)*m5_w' as='((1-int(500e-3)*2)*175e-9+(2-int(1.0)*2)*250e-9)*m5_w' pd='(1-int(500e-3)*2)*(350e-9+2*m5_w)+(2-int(1.0)*2)*(200e-9+1*m5_w)' ps='(1-int(500e-3)*2)*(350e-9+2*m5_w)+(2-int(1.0)*2)*(500e-9+3*m5_w)' nrd='(1-int(500e-3)*2)*(100e-9/m5_w)+(2-int(1.0)*2)*(100e-9/m5_w)' nrs='(1-int(500e-3)*2)*(100e-9/m5_w)+(2-int(1.0)*2)*(100e-9/m5_w)' sa=175e-9 sb=175e-9 sca=0 scb=0 scc=0
m4 net2 ibias vss vss nch_lvt l=m4_l w='m4_w*1' m=1 nf=1 sd=200e-9 ad='((1-int(500e-3)*2)*175e-9+(2-int(1.0)*2)*100e-9)*m4_w' as='((1-int(500e-3)*2)*175e-9+(2-int(1.0)*2)*250e-9)*m4_w' pd='(1-int(500e-3)*2)*(350e-9+2*m4_w)+(2-int(1.0)*2)*(200e-9+1*m4_w)' ps='(1-int(500e-3)*2)*(350e-9+2*m4_w)+(2-int(1.0)*2)*(500e-9+3*m4_w)' nrd='(1-int(500e-3)*2)*(100e-9/m4_w)+(2-int(1.0)*2)*(100e-9/m4_w)' nrs='(1-int(500e-3)*2)*(100e-9/m4_w)+(2-int(1.0)*2)*(100e-9/m4_w)' sa=175e-9 sb=175e-9 sca=0 scb=0 scc=0
m2 vout vn net2 net2 nch_lvt l=m2_l w='m2_w*1' m=1 nf=1 sd=200e-9 ad='((1-int(500e-3)*2)*175e-9+(2-int(1.0)*2)*100e-9)*m2_w' as='((1-int(500e-3)*2)*175e-9+(2-int(1.0)*2)*250e-9)*m2_w' pd='(1-int(500e-3)*2)*(350e-9+2*m2_w)+(2-int(1.0)*2)*(200e-9+1*m2_w)' ps='(1-int(500e-3)*2)*(350e-9+2*m2_w)+(2-int(1.0)*2)*(500e-9+3*m2_w)' nrd='(1-int(500e-3)*2)*(100e-9/m2_w)+(2-int(1.0)*2)*(100e-9/m2_w)' nrs='(1-int(500e-3)*2)*(100e-9/m2_w)+(2-int(1.0)*2)*(100e-9/m2_w)' sa=175e-9 sb=175e-9 sca=0 scb=0 scc=0
m0 net3 vp net2 net2 nch_lvt l=m0_l w='m0_w*1' m=1 nf=1 sd=200e-9 ad='((1-int(500e-3)*2)*175e-9+(2-int(1.0)*2)*100e-9)*m0_w' as='((1-int(500e-3)*2)*175e-9+(2-int(1.0)*2)*250e-9)*m0_w' pd='(1-int(500e-3)*2)*(350e-9+2*m0_w)+(2-int(1.0)*2)*(200e-9+1*m0_w)' ps='(1-int(500e-3)*2)*(350e-9+2*m0_w)+(2-int(1.0)*2)*(500e-9+3*m0_w)' nrd='(1-int(500e-3)*2)*(100e-9/m0_w)+(2-int(1.0)*2)*(100e-9/m0_w)' nrs='(1-int(500e-3)*2)*(100e-9/m0_w)+(2-int(1.0)*2)*(100e-9/m0_w)' sa=175e-9 sb=175e-9 sca=0 scb=0 scc=0
m3 vout net3 vdd vdd pch_lvt l=m3_l w='m3_w*1' m=1 nf=1 sd=200e-9 ad='((1-int(500e-3)*2)*175e-9+(2-int(1.0)*2)*100e-9)*m3_w' as='((1-int(500e-3)*2)*175e-9+(2-int(1.0)*2)*250e-9)*m3_w' pd='(1-int(500e-3)*2)*(350e-9+2*m3_w)+(2-int(1.0)*2)*(200e-9+1*m3_w)' ps='(1-int(500e-3)*2)*(350e-9+2*m3_w)+(2-int(1.0)*2)*(500e-9+3*m3_w)' nrd='(1-int(500e-3)*2)*(100e-9/m3_w)+(2-int(1.0)*2)*(100e-9/m3_w)' nrs='(1-int(500e-3)*2)*(100e-9/m3_w)+(2-int(1.0)*2)*(100e-9/m3_w)' sa=175e-9 sb=175e-9 sca=0 scb=0 scc=0
m1 net3 net3 vdd vdd pch_lvt l=m1_l w='m1_w*1' m=1 nf=1 sd=200e-9 ad='((1-int(500e-3)*2)*175e-9+(2-int(1.0)*2)*100e-9)*m1_w' as='((1-int(500e-3)*2)*175e-9+(2-int(1.0)*2)*250e-9)*m1_w' pd='(1-int(500e-3)*2)*(350e-9+2*m1_w)+(2-int(1.0)*2)*(200e-9+1*m1_w)' ps='(1-int(500e-3)*2)*(350e-9+2*m1_w)+(2-int(1.0)*2)*(500e-9+3*m1_w)' nrd='(1-int(500e-3)*2)*(100e-9/m1_w)+(2-int(1.0)*2)*(100e-9/m1_w)' nrs='(1-int(500e-3)*2)*(100e-9/m1_w)+(2-int(1.0)*2)*(100e-9/m1_w)' sa=175e-9 sb=175e-9 sca=0 scb=0 scc=0
.ends DUT
