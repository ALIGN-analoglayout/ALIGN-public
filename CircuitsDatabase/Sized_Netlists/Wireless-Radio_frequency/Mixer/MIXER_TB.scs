// Design cell name: tb_Mixer
simulator lang=spectre
global 0
parameters Fin freq2=8.3G freq1=8.2G pac=-10 ibias=1.5m

// INCLUDE YOUR MODELS HERE
include "Model_path" section=tt

// test_qmeng/MIXER_RFBIAS_RES/schematic
subckt MIXER_RFBIAS_RES M P tail_bias
R3 (P net9 ) res l=6u w=1u m=1 mf=(1)

R0 (net9 tail_bias ) res l=6u w=1u m=1 mf=(1)

R1 (tail_bias net05 ) res l=6u w=1u m=1 mf=(1)

R2 (net05 M ) res l=6u w=1u m=1 mf=(1)

ends MIXER_RFBIAS_RES

// test_qmeng/MIXER_LOSWBIAS_RES/schematic
subckt MIXER_LOSWBIAS_RES MIXER_LOBIAS VDD VSS
R5 (VDD net050 ) res l=4u w=1u m=1 mf=(1)

R4 (net031 net034 ) res l=4u w=1u m=1 mf=(1)

R9 (net049 net031 ) res l=4u w=1u m=1 mf=(1)

R6 (net050 net051 ) res l=4u w=1u m=1 mf=(1)

R7 (net051 MIXER_LOBIAS ) res l=4u w=1u m=1 mf=(1)

R8 (MIXER_LOBIAS net049 ) res l=4u w=1u m=1 mf=(1)

R0 (net039 VSS ) res l=4u w=1u m=1 mf=(1)

R1 (net033 net039 ) res l=4u w=1u m=1 mf=(1)

R3 (net034 net036 ) res l=4u w=1u m=1 mf=(1)

R2 (net036 net033 ) res l=4u w=1u m=1 mf=(1)

ends MIXER_LOSWBIAS_RES

// PhasedArray_WB_copy/MIXER_LOAD_RES_HBW/schematic
subckt MIXER_LOAD_RES_HBW A B
R4 (B B ) res l=13.0u w=1u m=1 mf=(1)

R0 (A net06 ) res l=13.0u w=1u m=1 mf=(1)

R1 (net06 net05 ) res l=13.0u w=1u m=1 mf=(1)

R3 (net05 B ) res l=13.0u w=1u m=1 mf=(1)

ends MIXER_LOAD_RES_HBW

// PhasedArray_WB_copy/Mixer/schematic
subckt Mixer IFM IFP LOM LOP MIXER_TAIL_IIN OUTM OUTP RFM RFP VDD VSS
    M35 (net051 tailm VSS VSS) nmos lr=240.0n wr=3.6u nr=12 sigma=1 m=1 M34 (net039 tailp VSS VSS) nmos lr=240.0n wr=3.6u nr=12 sigma=1 m=1 M44\<1\> (VSS MIXER_TAIL_IIN VSS VSS) nmos lr=240.0n wr=3.6u nr=2 sigma=1 m=1
    M44\<2\> (VSS MIXER_TAIL_IIN VSS VSS) nmos lr=240.0n wr=3.6u nr=2 sigma=1 m=1
    M44\<3\> (VSS MIXER_TAIL_IIN VSS VSS) nmos lr=240.0n wr=3.6u nr=2 sigma=1 m=1
    M44\<4\> (VSS MIXER_TAIL_IIN VSS VSS) nmos lr=240.0n wr=3.6u nr=2 sigma=1 m=1
    M44\<5\> (VSS MIXER_TAIL_IIN VSS VSS) nmos lr=240.0n wr=3.6u nr=2 sigma=1 m=1
    M44\<6\> (VSS MIXER_TAIL_IIN VSS VSS) nmos lr=240.0n wr=3.6u nr=2 sigma=1 m=1
    M44\<7\> (VSS MIXER_TAIL_IIN VSS VSS) nmos lr=240.0n wr=3.6u nr=2 sigma=1 m=1
    M44\<8\> (VSS MIXER_TAIL_IIN VSS VSS) nmos lr=240.0n wr=3.6u nr=2 sigma=1 m=1
    M43 (VSS VSS VSS VSS) nmos lr=60n wr=2u nr=4 sigma=1 m=2 M38 (MIXER_TAIL_IIN MIXER_TAIL_IIN VSS VSS) nmos lr=240.0n wr=3.6u nr=2 sigma=1 m=1
    M39 (pbias MIXER_TAIL_IIN VSS VSS) nmos lr=240.0n wr=3.6u nr=2 sigma=1 m=1
    M7 (IFM Oscp net039 net039) nmos lr=60n wr=2u nr=4 sigma=1 m=1 M13 (IFP Oscp net051 net051) nmos lr=60n wr=2u nr=4 sigma=1 m=1 M12 (IFM Oscm net051 net051) nmos lr=60n wr=2u nr=4 sigma=1 m=1 M11 (IFP Oscm net039 net039) nmos lr=60n wr=2u nr=4 sigma=1 m=1 M29 (VDD VDD VDD VDD) pmos lr=240.0n wr=2.05u nr=8 sigma=1 m=2 M16 (pbias pbias VDD VDD) pmos lr=240.0n wr=2.05u nr=8 sigma=1 m=2 M24 (IFP pbias VDD VDD) pmos lr=240.0n wr=2.05u nr=24 sigma=1 m=2 M23 (IFM pbias VDD VDD) pmos lr=240.0n wr=2.05u nr=24 sigma=1 m=2 I29 (tailm tailp MIXER_TAIL_IIN) MIXER_RFBIAS_RES
    I12 (Oscp VDD VSS) MIXER_LOSWBIAS_RES
    I21 (Oscm VDD VSS) MIXER_LOSWBIAS_RES
    I33 (IFP VDD) MIXER_LOAD_RES_HBW
    I17 (IFM VDD) MIXER_LOAD_RES_HBW
R1\<1\> (VSS net040\<0\> ) res l=13.0u w=1u m=1 mf=(1)

R1\<2\> (VSS net040\<1\> ) res l=13.0u w=1u m=1 mf=(1)

R1\<3\> (VSS net040\<2\> ) res l=13.0u w=1u m=1 mf=(1)

R1\<4\> (VSS net040\<3\> ) res l=13.0u w=1u m=1 mf=(1)

    C15 (LOP Oscp VSS) cap lt=32.0u wt=16.0u lay=7 m=1 C6 (RFM tailm VSS) cap lt=22.0u wt=22.0u lay=7 m=1 C7 (RFP tailp VSS) cap lt=22.0u wt=22.0u lay=7 m=1 C14 (LOM Oscm VSS) cap lt=32.0u wt=16.0u lay=7 m=1 R2 (IFP OUTP ) res l=6u w=1u m=1 mf=(1)

R5\<1\> (VSS net043\<0\> ) res l=6u w=1u m=1 mf=(1)

R5\<2\> (VSS net043\<1\> ) res l=6u w=1u m=1 mf=(1)

R5\<3\> (VSS net043\<2\> ) res l=6u w=1u m=1 mf=(1)

R5\<4\> (VSS net043\<3\> ) res l=6u w=1u m=1 mf=(1)

R0 (OUTM IFM ) res l=6u w=1u m=1 mf=(1)

ends Mixer

// analogLib/ideal_balun/schematic
subckt ideal_balun d c p n
    K0 (d 0 p c) transformer n1=2
    K1 (d 0 c n) transformer n1=2
ends ideal_balun

// PhasedArray_WB_copy/tb_Mixer/schematic
I11 (BBM BBP LOM LOP net5 OUTM OUTP RFM RFP Vdd 0) Mixer
V0 (Vdd 0) vsource dc=1 type=dc
I1 (Vdd net5) isource dc=ibias type=dc
C0 (OUTP 0) capacitor c=40f
C10 (OUTM 0) capacitor c=40f
V5 (net04 0) vsource dc=0 type=sine ampl=100m freq=Fin fundname="flo"
V1 (net4 0) vsource dc=0 type=sine ampl=800m freq=8G fundname="flo"
I5 (net04 0 RFP RFM) ideal_balun
I4 (net4 0 LOP LOM) ideal_balun
R3 (0 0) resistor r=50 isnoisy=no
PORT0 (net06 0) port r=50 type=sine
simulatorOptions options temp=27
dcOp dc
sweeppss sweep param=pac start=-30 stop=0 step=3 {
  pss pss fund=100M harms=5 errpreset=conservative tstab=2n
+ annotate=status

  pac pac sweeptype=relative relharmnum=1 start=1k stop=20G
+ lin=161 maxsideband=15 annotate=status
  pnoise ( OUTP OUTM ) pnoise sweeptype=absolute start=1k
+ stop=1G lin=161 maxsideband=15 iprobe=PORT0 refsideband=-1
+ annotate=status
}
