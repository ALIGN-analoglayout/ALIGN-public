simulator lang=spectre
global 0 vdd!

// EQ_01012020/SDC_top/schematic
N0 (vd net1 net11 0) nfet m=1 l=14n nfin=24 nf=1
N1 (net11 net1 vs 0) nfet m=1 l=14n nfin=24 nf=1
R2 (net1 vb) resistor r=15000
R1 (0 vs) resistor r=1080
R0 (vd vdd!) resistor r=1080
C2 (vs 0) capacitor c=10e-15
C1 (vd 0) capacitor c=10e-15
V1 (vdd! 0) vsource dc=vps type=dc
V0 (vb 0) vsource dc=vbias type=dc
V2 (vin 0) vsource dc=0 mag=1 type=sine ampl=200m freq=1G
C0 (vin net1) capacitor c=79.5e-15
simulatorOptions options temp=27
dcOp dc
ac ac start=1000 stop=1000G dec=10
tran tran stop=10n errpreset=conservative
