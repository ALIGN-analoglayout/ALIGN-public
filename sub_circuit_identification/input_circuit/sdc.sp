// Design: ALIGN_project/sdc
simulator lang=spectre
global 0 vdd!

parameters rbias=10k vbias=0.49 cload=10f rload=55 fin_count=140 vdd=0.8

// directory of the library files removed.

// ALIGN_project_test/sdc/schematic
subckt nfet2x (d g s b)
	parameters p1=2
	MN0 d g n1 b	nfet l=0.014u nfin=p1
	MN1 n1 g s b	nfet l=0.014u nfin=p1
ends nfet2x

xM0 (vd vbias vs 0) nfet2x p1=fin_count
R3 (vbias net010) resistor r=rbias
R2 (vchannel 0) resistor r=50
R1 (vdd! vd) resistor r=rload
R0 (vs 0) resistor r=rload
V2 (net010 0) vsource dc=vbias mag=0 type=dc // bias voltage
V1 (vdd! 0) vsource dc=vdd type=dc // power supply
C0 (vchannel vbias) capacitor c=60e-15
CL1 (vd 0) capacitor c=cload
CL2 (vs 0) capacitor c=cload

V3 (vchannel 0) vsource dc=0 mag=1 type=sine sinedc=0 ampl=200m freq=1G
simulatorOptions options temp=27
dcOp dc
//dc dc param=fin_count start=3 stop=300 step=2 oppoint=rawfile maxiters=150 // maxsteps=10000 annotate=status
ac1 ac start=1K stop=10000G dec=10
tran tran stop=5n step=0.001*10n errpreset=conservative
// use step size here, conservative mode

save xM0.MN0:all xM0.MN1:all
