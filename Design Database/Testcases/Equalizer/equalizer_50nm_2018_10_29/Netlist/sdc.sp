// Design: ALIGN_project/sdc
simulator lang=spectre
global 0 vdd!
parameters rbias=60k vbias=1 W=50u cload=10f
include "./model_file_50nm.inc"

M0 (vd vbias vs 0) N_50n w=W l=100n
R6 (vbias net010) resistor r=rbias
R2 (vchannel 0) resistor r=50
R1 (vdd! vd) resistor r=55
R0 (vs 0) resistor r=55
V2 (net010 0) vsource dc=vbias mag=0 type=dc
V1 (vdd! 0) vsource dc=1 type=dc
C0 (vchannel vbias) capacitor c=2.4p
CL1 (vd 0) capacitor c=cload
CL2 (vs 0) capacitor c=cload

V3 (vchannel 0) vsource dc=0 mag=250m type=sine sinedc=0 ampl=300m freq=1G
simulatorOptions options temp=27
dcOp dc
dc dc param=W start=10u stop=500u step=1000
ac ac start=1K stop=100G dec=10
tran tran stop=5n
save M0:d
